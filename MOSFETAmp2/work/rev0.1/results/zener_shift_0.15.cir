MOSFETAmp2 zener_shift_0.15 - approximate models
* MOSFETAmp2 single channel development circuit; external nodes match KiCad nets.
* Preliminary models: see models/README.md. No SOA or thermal runaway simulation.
.param VS=15 RV=2000 CC=330p VTON=3.4 VTOP=-3.77 KPN=20 KPP=7.07
.param TS=27 TD=27
.model BC546B NPN(IS=2.39E-14 NF=1.008 ISE=3.55E-15 NE=1.541 BF=294.3 IKF=0.1357 VAF=63.2 NR=1.004 ISC=6.27E-14 NC=1.243 BR=7.946 IKR=0.1144 VAR=25.9 RB=1 IRB=1.00E-06 RBM=1 RE=0.4683 RC=0.85 XTB=0 EG=1.11 XTI=3 CJE=1.36E-11 VJE=0.65 MJE=0.3279 TF=4.39E-10 XTF=120 VTF=2.643 ITF=0.7495 PTF=0 CJC=3.73E-12 VJC=0.3997 MJC=0.2955 XCJC=0.6193 TR=1.00E-32 CJS=0 VJS=0.75 MJS=0.333 FC=0.9579)
.model BC556B PNP(IS=3.83E-14 NF=1.008 ISE=1.22E-14 NE=1.528 BF=344.4 IKF=0.08039 VAF=21.11 NR=1.005 ISC=2.85E-13 NC=1.28 BR=14.84 IKR=0.047 VAR=32.02 RB=1 IRB=1.00E-06 RBM=1 RE=0.6202 RC=0.5713 XTB=0 EG=1.11 XTI=3 CJE=1.23E-11 VJE=0.6106 MJE=0.378 TF=5.60E-10 XTF=3.414 VTF=5.23 ITF=0.1483 PTF=0 CJC=1.08E-11 VJC=0.1022 MJC=0.3563 XCJC=0.6288 TR=1.00E-32 CJS=0 VJS=0.75 MJS=0.333 FC=0.8027)
* Author-created engineering approximations; NOT manufacturer models.
.model DSCH D(IS=100n N=1.1 RS=2 CJO=10p VJ=0.35 M=0.5 TT=0 BV=100)
.model BD139A NPN(IS=2e-13 BF=100 VAF=80 IKF=0.5 RB=10 RC=0.2 RE=0.1 CJE=80p CJC=25p TF=0.8n TR=100n)
.model BD140A PNP(IS=2e-13 BF=100 VAF=80 IKF=0.5 RB=10 RC=0.2 RE=0.1 CJE=90p CJC=30p TF=1.2n TR=100n)
.model D4148 D(IS=2.5n RS=0.6 N=1.75 CJO=4p TT=4n BV=100)
.model Z5V1 D(IS=1n N=1.5 RS=10 BV=5.1 IBV=5m CJO=100p)
.model Z4V3 D(IS=1n N=1.5 RS=15 BV=4.45 IBV=5m CJO=100p)
.model Z10 D(IS=1n N=1.5 RS=3 BV=10 IBV=5m CJO=80p)
.subckt IRF540_APPROX D G S
M1 DI GI SI SI NAP L=1u W=1u TEMP=27
RG G GI 2
RD D DI 0.025
RS SI S 0.02
CGS GI SI 1.92n
CGD GI DI 40p
DB SI DI DNAP
.model NAP NMOS(LEVEL=1 VTO={VTON} KP={KPN} LAMBDA=0.003)
.model DNAP D(IS=10n RS=0.02 CJO=250p VJ=0.7 M=0.5 TT=120n BV=100)
.ends
.subckt IRF9540_APPROX D G S
M1 DI GI SI SI PAP L=1u W=1u TEMP=27
RG G GI 7
RD D DI 0.046
RS SI S 0.043
CGS GI SI 1.06n
CGD GI DI 240p
DB DI SI DPAP
.model PAP PMOS(LEVEL=1 VTO={VTOP} KP={KPP} LAMBDA=0.003)
.model DPAP D(IS=1n N=1.5 RS=0.03 CJO=400p VJ=0.7 M=0.5 TT=160n BV=100)
.ends

.subckt AMP IN OUT VP VN 0
* PNP input pair, NPN mirror, PNP tail source (about 2 mA)
R1 IN B1 1k
R2 B1 0 22k
C1 B1 0 220p
R3 OUT FB 22k
R4 FB 0 2.2k
Q1 C1N FB E1 BC556B
Q2 C2N B1 E2 BC556B
R5 E1 TAIL 100
R6 E2 TAIL 100
Q3 C1N C1N VN BC546B
Q4 C2N C1N VN BC546B
Q5 TAIL TREF TE BC556B
R7 VP TE 330
D1 TDI TREF D4148
D2 VP TDI D4148
R8 TREF VN 12k
* VAS with 6 mA current-source load
Q15 VP C2N VB BC546B
Q6 BN VB VE BD139A
R9 VE VN 100
R10 VB VN 10k
D7 C2N CLD D4148
D8 CLD BN DSCH
C2 C2N BN {CC}
Q7 BP TREF VCE BC556B
R11 VP VCE 100
* Offset + VBE multiplier. RV is rheostat, maximum resistance = minimum bias.
DZ1 BC BP Z4V3
Q8 BC BB BN BD139A TEMP={TS}
R12 BC BB 1k
R13 BB BN 47k
R14 BB BW 130
RV1 BW BN {RV}
C3 BP BN 100n
* Emitter-follower gate drivers
Q9 VP BP DN BD139A TEMP={TD}
Q10 VN BN DP BD140A TEMP={TD}
R15 DN OUT 2.2k
R16 DP OUT 2.2k
R17 DN GN 100
R18 DP GP 100
XQ11 VP GN SN IRF540_APPROX
XQ12 VN GP SP IRF9540_APPROX
R19 SN OUT 0.33
R20 OUT SP 0.33
R21 GN SN 47k
R22 GP SP 47k
DZ2 SN GN Z10
DZ3 GP SP Z10
* Differential-input overload clamps
D5 B1 FB D4148
D6 FB B1 D4148
* Zobel and per-channel local supply bypass
R25 OUT ZB 10
C4 ZB 0 100n
C5 VP 0 220u
C6 0 VN 220u
C7 VP 0 100n
C8 0 VN 100n
.ends AMP

.param RV=37.69710010189562 VTON=3.2079999999999997 VTOP=-3.578 KPN=16.00987414603376 KPP=5.659490510622934 TS=75 TD=75
VP VP 0 {VS}
VN VN 0 {-VS}
VIN IN 0 DC 0 AC 1
XA IN OUT VP VN 0 AMP
LOUT OUT SPK 0.7u
RLDCR OUT SPK 10
RL SPK 0 8

.options reltol=1e-5 abstol=1e-10 vntol=1e-7
.control
set noaskquit
set wr_singlescale
set wr_vecnames
op
print v(out) v(xa.sn) v(xa.sp) v(xa.gn) v(xa.gp) v(xa.bp) v(xa.bn) i(vp) i(vn) v(xa.tail) v(xa.ve)
quit
.endc
.end
