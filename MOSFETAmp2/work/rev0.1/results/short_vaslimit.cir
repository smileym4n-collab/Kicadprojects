MOSFETAmp2 short_vaslimit - approximate models
.include channel.cir
.param RV=135.69616101713268
VP VP 0 {VS}
VN VN 0 {-VS}
VIN IN 0 SIN(0 1 1000)
XA IN OUT VP VN 0 AMP
LOUT OUT SPK 0.7u
RLDCR OUT SPK 10
RL SPK 0 8
VCTRL CTRL 0 PWL(0 0 3m 0 3.001m 1 4m 1 4.001m 0)
SSHORT SPK 0 CTRL 0 SSH
.model SSH SW(RON=.1 ROFF=1e9 VT=.5 VH=.1)
.options reltol=1e-5 abstol=1e-10 vntol=1e-7
.control
set noaskquit
set wr_singlescale
set wr_vecnames
tran 1e-06 0.008 0 1e-06
wrdata results/short_vaslimit.txt v(in) v(spk) v(out) v(xa.sn) v(xa.sp) v(xa.gn) v(xa.gp) i(vp) i(vn)
quit
.endc
.end
