MOSFETAmp2 debug_temp - approximate models
.include channel.cir
.param RV=178.6877 VTON=3.308 VTOP=-3.678 KPN=17.9 KPP=6.32 TS=50 TD=50
VP VP 0 {VS}
VN VN 0 {-VS}
VIN IN 0 DC 0 AC 1
XA IN OUT VP VN 0 AMP
LOUT OUT SPK 0.7u
RLDCR OUT SPK 10
RL SPK 0 8

.options reltol=1e-5 abstol=1e-10 vntol=1e-7
.control
set noaskquit
set wr_singlescale
set wr_vecnames
op
print all
tran .1u 3m 0 .1u
wrdata results/debug_temp.txt v(spk) v(xa.fb) v(xa.b1) v(xa.c2n) v(xa.ve) v(xa.bp) v(xa.bn)
quit
.endc
.end
