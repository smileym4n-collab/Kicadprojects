MOSFETAmp2 square_4R - approximate models
.include channel.cir
.param RV=37.69710010189562
VP VP 0 {VS}
VN VN 0 {-VS}
VIN IN 0 PULSE(-0.2 0.2 0 200n 200n 4.9800000000000004e-05 0.0001)
XA IN OUT VP VN 0 AMP
LOUT OUT SPK 0.7u
RLDCR OUT SPK 10
RL SPK 0 4

.options reltol=1e-5 abstol=1e-10 vntol=1e-7
.control
set noaskquit
set wr_singlescale
set wr_vecnames
tran 1.25e-07 0.0008 0 1.25e-07
wrdata results/square_4R.txt v(in) v(spk) v(out) v(xa.sn) v(xa.sp) v(xa.gn) v(xa.gp) i(vp) i(vn)
quit
.endc
.end
