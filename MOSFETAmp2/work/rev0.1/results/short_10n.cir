MOSFETAmp2 short_10n - approximate models
* MOSFETAmp2 single channel development circuit; external nodes match KiCad nets.
* Preliminary models: see models/README.md. No SOA or thermal runaway simulation.
.param VS=15 RV=2000 CC=220p VTON=3.4 VTOP=-3.77 KPN=20 KPP=7.07
.param TS=27 TD=27
.include models/devices.lib
.subckt AMP IN OUT VP VN 0
* PNP input pair, NPN mirror, PNP tail source (about 2 mA)
R1 IN B1 1k
R2 B1 0 22k
C1 B1 0 220p
R3 OUT FB 22k
R4 FB 0 2.2k
Q1 C1N FB E1 BC556B
Q2 C2N B1 E2 BC556B
R5 E1 TAIL 100
R6 E2 TAIL 100
Q3 C1N C1N VN BC546B
Q4 C2N C1N VN BC546B
Q5 TAIL TREF TE BC556B
R7 VP TE 330
D1 TDI TREF D4148
D2 VP TDI D4148
R8 TREF VN 12k
* VAS with 6 mA current-source load
Q15 VP C2N VB BC546B
Q6 BN VB VE BD139A
R9 VE VN 100
R10 VB VN 10k
D7 C2N CLD D4148
D8 CLD BN DSCH
C2 C2N BN {CC}
Q7 BP TREF VCE BC556B
R11 VP VCE 100
* Offset + VBE multiplier. RV is rheostat, maximum resistance = minimum bias.
DZ1 BC BP Z4V3
Q8 BC BB BN BD139A TEMP={TS}
R12 BC BB 3.3k
R13 BB BN 2.2k
R14 BB BW 680
RV1 BW BN {RV}
C3 BP BN 10n
* Emitter-follower gate drivers
Q9 VP BP DN BD139A TEMP={TD}
Q10 VN BN DP BD140A TEMP={TD}
R15 DN OUT 2.2k
R16 DP OUT 2.2k
R17 DN GN 100
R18 DP GP 100
XQ11 VP GN SN IRF540_APPROX
XQ12 VN GP SP IRF9540_APPROX
R19 SN OUT 0.33
R20 OUT SP 0.33
R21 GN SN 47k
R22 GP SP 47k
DZ2 SN GN Z10
DZ3 GP SP Z10
* Source-sense limiter, typical threshold about 1.8 A; NOT SOA protection.
R23 SN LN 1k
R24 SP LP 1k
Q13 BP LN OUT BC546B
Q14 BN LP OUT BC556B
D3 OUT LN D4148
D4 LP OUT D4148
* Differential-input overload clamps
D5 B1 FB D4148
D6 FB B1 D4148
* Zobel and per-channel local supply bypass
R25 OUT ZB 10
C4 ZB 0 100n
C5 VP 0 220u
C6 0 VN 220u
C7 VP 0 100n
C8 0 VN 100n
.ends AMP

.param RV=135.69616101713268
VP VP 0 {VS}
VN VN 0 {-VS}
VIN IN 0 SIN(0 1 1000)
XA IN OUT VP VN 0 AMP
LOUT OUT SPK 0.7u
RLDCR OUT SPK 10
RL SPK 0 8
VCTRL CTRL 0 PWL(0 0 3m 0 3.001m 1 4m 1 4.001m 0)
SSHORT SPK 0 CTRL 0 SSH
.model SSH SW(RON=.1 ROFF=1e9 VT=.5 VH=.1)
.options reltol=1e-5 abstol=1e-10 vntol=1e-7
.control
set noaskquit
set wr_singlescale
set wr_vecnames
tran 1e-06 0.008 0 1e-06
wrdata results/short_10n.txt v(in) v(spk) v(out) v(xa.sn) v(xa.sp) v(xa.gn) v(xa.gp) i(vp) i(vn)
quit
.endc
.end
