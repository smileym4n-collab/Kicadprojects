MOSFETAmp2 frequency - approximate models
.include channel.cir
.param RV=37.69710010189562
VP VP 0 {VS}
VN VN 0 {-VS}
VIN IN 0 DC 0 AC 1
XA IN OUT VP VN 0 AMP
LOUT OUT SPK 0.7u
RLDCR OUT SPK 10
RL SPK 0 8

.options reltol=1e-5 abstol=1e-10 vntol=1e-7
.control
set noaskquit
set wr_singlescale
set wr_vecnames
ac dec 100 1 100meg
wrdata results/frequency.txt v(spk)
quit
.endc
.end
