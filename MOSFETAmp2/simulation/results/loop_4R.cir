MOSFETAmp2 loop_4R - approximate models
* MOSFETAmp2 single channel development circuit, Rev 0.2; external nodes match KiCad nets.
* Models: see models/README.md. No SOA, self-heating or electrothermal simulation.
* MOSFETs: models/mosfets_infineon.lib (run.py substitutes mosfets_authored.lib if MOSFET_MODELS=authored).
* DVN/DVP: imposed |Vth| shift (V, + = higher threshold), KPS: imposed KP scale. TS: Q8 sensor temperature,
* TD: driver and board bias-part temperature. RV: trim rheostat, RE: select-on-test, R13: slope select.
.param VS=15 RV=200 RE=1k R13=1k CC=330p DVN=0 DVP=0 KPS=1 LEDEG=2.3
.param TS=27 TD=27
.include models/devices.lib
.include models/mosfets_infineon.lib
.subckt AMP IN OUT VP VN 0
* PNP input pair, NPN mirror, PNP tail source (about 2 mA)
R1 IN B1 1k
R2 B1 0 22k
C1 B1 0 220p
R3 OUT FB 22k
R4 FB 0 2.2k
VTEST FBI FB DC 0 AC 1
Q1 C1N FBI E1 BC556B
Q2 C2N B1 E2 BC556B
R5 E1 TAIL 100
R6 E2 TAIL 100
Q3 C1N C1N VN BC546B
Q4 C2N C1N VN BC546B
Q5 TAIL TREF TE BC556B
R7 VP TE 330
D1 TDI TREF D4148
D2 VP TDI D4148
R8 TREF VN 12k
* VAS with 6 mA current-source load
Q15 VP C2N VB BC546B
Q6 BN VB VE BD139A
R9 VE VN 100
R10 VB VN 10k
D7 C2N CLD D4148
D8 CLD BN DSCH
C2 C2N BN {CC}
Q7 BP TREF VCE BC556B
R11 VP VCE 100
* Bias spreader (Rev 0.2): two board diodes track the drivers; Q8 on the heatsink has a FIXED ratio
* 1 + 3k9/R13 (slope select); Q16 draws (V(LED) - VBE)/(RE + RV) from the Q8 base, adding 3k9 x I as a
* low-temperature-coefficient offset. RV is a rheostat: maximum resistance = minimum bias; RE open = no offset.
D9 BP BX1 D4148 TEMP={TD}
D12 BX1 BC D4148 TEMP={TD}
Q8 BC BB BN BD139A TEMP={TS}
R12 BC BB 3.9k
R13 BB BN {R13}
Q16 BB BREF BCE BC546B TEMP={TD}
R14 BCE BW {RE}
RV1 BW VN {RV}
D13 BREF VN LEDR TEMP={TD}
Q17 BREF TREF BLE BC556B TEMP={TD}
R27 VP BLE 680
C3 BP BN 100n
* Emitter-follower gate drivers
Q9 VP BP DN BD139A TEMP={TD}
Q10 VN BN DP BD140A TEMP={TD}
R15 DN OUT 2.2k
R16 DP OUT 2.2k
R17 DN GN 100
R18 DP GP 100
VTHN GN GNI DC {DVN}
XQ11 VP GNI SN MOSN
VTHP GPI GP DC {DVP}
XQ12 VN GPI SP MOSP
R19 SN OUT 0.33
R20 OUT SP 0.33
R21 GN SN 47k
R22 GP SP 47k
DZ2 SN GN Z10
DZ3 GP SP Z10
* Differential-input overload clamps
D5 B1 FB D4148
D6 FB B1 D4148
* Zobel and per-channel local supply bypass
R25 OUT ZB 10
C4 ZB 0 100n
C5 VP 0 220u
C6 0 VN 220u
C7 VP 0 100n
C8 0 VN 100n
.ends AMP

.param RV=128.19205597182324
VP VP 0 {VS}
VN VN 0 {-VS}
VIN IN 0 DC 0 AC 0
XA IN OUT VP VN 0 AMP
LOUT OUT SPK 0.7u
RLDCR OUT SPK 10
RL SPK 0 4

.options reltol=1e-5 abstol=1e-10 vntol=1e-7
.control
set noaskquit
set wr_singlescale
set wr_vecnames
ac dec 100 1 100meg
let ret=-v(xa.fb)/v(xa.fbi)
wrdata results/loop_4R.txt ret
quit
.endc
.end
