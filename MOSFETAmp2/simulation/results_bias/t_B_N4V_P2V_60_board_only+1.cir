MOSFETAmp2 bias study t_B_N4V_P2V_60_board_only+1 variant B models authored
.param R2B=1000 VS=15 RV=160.36689421043891 RE=1500 VZ=4.3 TCZ=-0.0016 RZ=15 LEDEG=2.3 TS=27 TB=42 DVN=0.6000000000000001 DVP=-1.77 KPS=1.0 KPN=20 KPP=7.07 VTON=3.4 VTOP=-3.77 CC=330p
.include models/devices.lib
.SUBCKT irf540n_k 1 2 3
* SPICE3 MODEL WITH THERMAL RC NETWORK
**************************************
*      Model Generated by MODPEX     *
*Copyright(c) Symmetry Design Systems*
*         All Rights Reserved        *
*    UNPUBLISHED LICENSED SOFTWARE   *
*   Contains Proprietary Information *
*      Which is The Property of      *
*     SYMMETRY OR ITS LICENSORS      *
*Commercial Use or Resale Restricted *
*   by Symmetry License Agreement    *
**************************************
* Model generated on Sep  5, 01
* MODEL FORMAT: SPICE3
* Symmetry POWER MOS Model (Version 1.0)
* External Node Designations
* Node 1 -> Drain
* Node 2 -> Gate
* Node 3 -> Source
M1 9 7 8 8 MM L=100u W=100u
.MODEL MM NMOS LEVEL=1 IS=1e-32
+VTO=3.58173 LAMBDA=0.00806114 KP={112.25*KPS}
+CGSO=1.896e-05 CGDO=1e-11
RS 8 3 0.025918
D1 3 1 MD
.MODEL MD D IS=1.565e-11 RS=0.006486 N=1.1328 BV=100
+IBV=0.00025 EG=1.2 XTI=3.32496 TT=0
+CJO=1.16e-09 VJ=3.16363 M=0.840542 FC=0.5
RDS 3 1 1e+06
RD 9 1 0.0130608
RG 2 7 6.45271
D2 4 5 MD1
* Default values used in MD1:
*   RS=0 EG=1.11 XTI=3.0 TT=0
*   BV=infinite IBV=1mA
.MODEL MD1 D IS=1e-32 N=50
+CJO=1.30485e-09 VJ=0.899032 M=0.9 FC=1e-08
D3 0 5 MD2
* Default values used in MD2:
*   EG=1.11 XTI=3.0 TT=0 CJO=0
*   BV=infinite IBV=1mA
.MODEL MD2 D IS=1e-10 N=0.4 RS=3e-06
RL 5 10 1
FI2 7 9 VFI2 -1
VFI2 4 0 0
EV16 10 0 9 7 1
CAP 11 10 2.35428e-09
FI1 7 9 VFI1 -1
VFI1 11 6 0
RCAP 6 10 1
D4 0 6 MD3
* Default values used in MD3:
*   EG=1.11 XTI=3.0 TT=0 CJO=0
*   RS=0 BV=infinite IBV=1mA
.MODEL MD3 D IS=1e-10 N=0.4
.ENDS irf540n_k
.SUBCKT irf9540n_k 1 2 3
**************************************
*      Model Generated by MODPEX     *
*Copyright(c) Symmetry Design Systems*
*         All Rights Reserved        *
*    UNPUBLISHED LICENSED SOFTWARE   *
*   Contains Proprietary Information *
*      Which is The Property of      *
*     SYMMETRY OR ITS LICENSORS      *
*Commercial Use or Resale Restricted *
*   by Symmetry License Agreement    *
**************************************
* Model generated on Aug 15, 17
* MODEL FORMAT: SPICE3
* Symmetry POWER MOS Model (Version 1.0)
* External Node Designations
* Node 1 -> Drain
* Node 2 -> Gate
* Node 3 -> Source
M1 9 7 8 8 MM L=100u W=100u
.MODEL MM PMOS LEVEL=1 IS=1e-32
+VTO=-3.74034 LAMBDA=0.00254531 KP={6.90462*KPS}
+CGSO=1.15995e-05 CGDO=1e-11
RS 8 3 0.0448511
D1 1 3 MD
.MODEL MD D IS=4.56468e-09 RS=0.00874877 N=1.45317 BV=100
+IBV=0.00025 EG=1.15553 XTI=3.00117 TT=1e-07
+CJO=9.64423e-10 VJ=0.500897 M=0.387171 FC=0.5
RDS 3 1 2e+07
RD 9 1 0.0421247
RG 2 7 6.66725
D2 5 4 MD1
* Default values used in MD1:
*   RS=0 EG=1.11 XTI=3.0 TT=0
*   BV=infinite IBV=1mA
.MODEL MD1 D IS=1e-32 N=50
+CJO=3.36744e-09 VJ=0.5 M=0.683702 FC=1e-08
D3 5 0 MD2
* Default values used in MD2:
*   EG=1.11 XTI=3.0 TT=0 CJO=0
*   BV=infinite IBV=1mA
.MODEL MD2 D IS=1e-10 N=0.4 RS=2.99982e-06
RL 5 10 1
FI2 7 9 VFI2 -1
VFI2 4 0 0
EV16 10 0 9 7 1
CAP 11 10 3.66446e-09
FI1 7 9 VFI1 -1
VFI1 11 6 0
RCAP 6 10 1
D4 6 0 MD3
* Default values used in MD3:
*   EG=1.11 XTI=3.0 TT=0 CJO=0
*   RS=0 BV=infinite IBV=1mA
.MODEL MD3 D IS=1e-10 N=0.4
.ENDS irf9540n_k

.model LEDR D(IS=2.7e-19 N=2 RS=10 EG={LEDEG} XTI=3 CJO=20p)
.model ZSEL D(IS=1n N=1.5 RS={RZ} BV={VZ} IBV=5m CJO=100p TBV1={TCZ/VZ})

.subckt AMP IN OUT VP VN 0
* PNP input pair, NPN mirror, PNP tail source (about 2 mA)
R1 IN B1 1k
R2 B1 0 22k
C1 B1 0 220p
R3 OUT FB 22k
R4 FB 0 2.2k
Q1 C1N FB E1 BC556B
Q2 C2N B1 E2 BC556B
R5 E1 TAIL 100
R6 E2 TAIL 100
Q3 C1N C1N VN BC546B
Q4 C2N C1N VN BC546B
Q5 TAIL TREF TE BC556B
R7 VP TE 330
D1 TDI TREF D4148 TEMP={TB}
D2 VP TDI D4148 TEMP={TB}
R8 TREF VN 12k
* VAS with 6 mA current-source load
Q15 VP C2N VB BC546B
Q6 BN VB VE BD139A
R9 VE VN 100
R10 VB VN 10k
D7 C2N CLD D4148
D8 CLD BN DSCH
C2 C2N BN {CC}
Q7 BP TREF VCE BC556B TEMP={TB}
R11 VP VCE 100
* Offset + VBE multiplier. RV is rheostat, maximum resistance = minimum bias.
DB1 BP BX1 D4148 TEMP={TB}
DB2 BX1 BC D4148 TEMP={TB}
Q8 BC BB BN BD139A TEMP={TS}
R12 BC BB 3.9k
R13 BB BN {R2B}
QCS BB BREF BCE BC546B TEMP={TB}
RE BCE BW {RE}
RV1 BW VN {RV}
DLED BREF VN LEDR TEMP={TB}
QLF BREF TREF BLE BC556B TEMP={TB}
RLF VP BLE 680
C3 BP BN 100n
* Emitter-follower gate drivers
Q9 VP BP DN BD139A TEMP={TB}
Q10 VN BN DP BD140A TEMP={TB}
R15 DN OUT 2.2k
R16 DP OUT 2.2k
R17 DN GN 100
R18 DP GP 100
VTHN GN GNI DC {DVN}
XQ11 VP GNI SN IRF540_APPROX
VTHP GPI GP DC {DVP}
XQ12 VN GPI SP IRF9540_APPROX
R19 SN OUT 0.33
R20 OUT SP 0.33
R21 GN SN 47k
R22 GP SP 47k
DZ2 SN GN Z10
DZ3 GP SP Z10
* Differential-input overload clamps
D5 B1 FB D4148
D6 FB B1 D4148
* Zobel and per-channel local supply bypass
R25 OUT ZB 10
C4 ZB 0 100n
C5 VP 0 220u
C6 0 VN 220u
C7 VP 0 100n
C8 0 VN 100n
.ends AMP

VP VP 0 {VS}
VN VN 0 {-VS}
VIN IN 0 DC 0
XA IN OUT VP VN 0 AMP
LOUT OUT SPK 0.7u
RLDCR OUT SPK 10
RL SPK 0 8
.options reltol=1e-5 abstol=1e-10 vntol=1e-7
.control
set noaskquit
set wr_singlescale
set wr_vecnames
op
print v(out) v(xa.sn) v(xa.sp) v(xa.bp) v(xa.bn) v(xa.bb) i(vp) i(vn)
quit
.endc
.end
